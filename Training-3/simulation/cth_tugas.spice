** sch_path: /home/nexus_is/Diices-Training-2026/Training-3/cth_tugas.sch
**.subckt cth_tugas
XM1 net2 net2 net1 net1 sky130_fd_pr__pfet_01v8 L=1.5 W=2.5 nf=1 ad='int((nf+1)/2) * W/nf * 0.29' as='int((nf+2)/2) * W/nf * 0.29'
+ pd='2*int((nf+1)/2) * (W/nf + 0.29)' ps='2*int((nf+2)/2) * (W/nf + 0.29)' nrd='0.29 / W' nrs='0.29 / W' sa=0 sb=0 sd=0 mult=1
XM2 net3 net2 net1 net1 sky130_fd_pr__pfet_01v8 L=1.5 W=2.5 nf=1 ad='int((nf+1)/2) * W/nf * 0.29' as='int((nf+2)/2) * W/nf * 0.29'
+ pd='2*int((nf+1)/2) * (W/nf + 0.29)' ps='2*int((nf+2)/2) * (W/nf + 0.29)' nrd='0.29 / W' nrs='0.29 / W' sa=0 sb=0 sd=0 mult=4 m=4
V1 net1 0 1.8
Vreff net2 net4 0
.save i(vreff)
Vout net3 0 0
.save i(vout)
I0 net4 0 1u
**** begin user architecture code
.lib /home/nexus_is/.ciel/volare/sky130/versions/0fe599b2afb6708d281543108caf8310912f54af/sky130A/libs.tech/combined/sky130.lib.spice tt

.control
 save all
 tran 1n 10n
 plot i(vreff) i(vout)

.endc

**** end user architecture code
**.ends
.end
