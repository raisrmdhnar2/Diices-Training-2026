** sch_path: /home/nexus_is/Diices-Training-2026/Training-3/tes.sch
**.subckt tes
XM1 net1 G 0 0 sky130_fd_pr__nfet_01v8 L=0.15 W=1 nf=1 ad='int((nf+1)/2) * W/nf * 0.29' as='int((nf+2)/2) * W/nf * 0.29' pd='2*int((nf+1)/2) * (W/nf + 0.29)'
+ ps='2*int((nf+2)/2) * (W/nf + 0.29)' nrd='0.29 / W' nrs='0.29 / W' sa=0 sb=0 sd=0 mult=1
Vmeas D net1 0
.save i(vmeas)
V1 G 0 0.9
V2 D 0 3
**** begin user architecture code
.lib /home/nexus_is/.ciel/volare/sky130/versions/0fe599b2afb6708d281543108caf8310912f54af/sky130A/libs.tech/combined/sky130.lib.spice tt

.control
save all
dc v2 0 1.8 0.01
plot i(vmeas)

.endc

**** end user architecture code
**.ends
.end
